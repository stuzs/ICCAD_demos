** Imaginary YFET test circuit
Y1 7 2 0 YFET
Vme1 1 7 0
Y2 3 4 1 YFET
Vg1 2 0 1.5
Vg2 4 0 2.5
R1 1 5 10
D1 5 0 DIODE
Ig 0 6 0.1
Vme2 6 3 0
Rg 6 0 50
