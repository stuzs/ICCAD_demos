* Simplest circuit of diode
i 0 1 1
r 1 0 1
d 1 0 d
