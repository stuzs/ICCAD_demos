* Example linear circuit added with a diode
* iz is also increased to 3A
rx 1 2 1
ry 2 3 1
rz 3 1 0.5
rg 1 0 1
ix 0 1 1
iz 0 3 3
* comment/uncomment the diode below to compare
d1 3 1 diode
